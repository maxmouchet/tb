** Profile: "SCHEMATIC1-bias"  [ Z:\MES DOCUMENTS\tb\SIT212\TP4\sit231_tp4-pspicefiles\schematic1\bias.sim ]

** Creating circuit file "bias.cir"
** WARNING: THIS AUTOMATICALLY GENERATED FILE MAY BE OVERWRITTEN BY SUBSEQUENT SIMULATIONS

*Libraries:
* Profile Libraries :
* Local Libraries :
* From [PSPICE NETLIST] section of C:\OrCAD\OrCAD_16.0_Demo\tools\PSpice\PSpice.ini file:
.lib "nom.lib"

*Analysis directives:
.TRAN  0 0.6ms 0
.PROBE V(*) I(*) W(*) D(*) NOISE(*)
.INC "..\SCHEMATIC1.net"

.END
